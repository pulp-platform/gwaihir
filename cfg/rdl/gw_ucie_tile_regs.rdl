// Copyright 2025 ETH Zurich and University of Bologna.
// Solderpad Hardware License, Version 0.51, see LICENSE for details.
// SPDX-License-Identifier: SHL-0.51

`ifndef __GW_UCIE_TILE_REGS_RDL__
`define __GW_UCIE_TILE_REGS_RDL__

addrmap gw_ucie_tile_regs {
    reg clock {
        field {
            desc = "Clock gate control for tile";
            hw = r;
            sw = rw;
            reset = 0; // Clock is disabled by default
        } en;
    } clk;

    reg rst_axi {
        desc = "Reset control for tile";
        field {
            desc = "active low reset signal for ucie axi domain";
            hw = r;
            sw = rw;
            reset = 0; // Tile is held in reset by default
        } n;
    } rst_axi;

    reg rst_apb {
        desc = "Reset control for tile";
        field {
            desc = "active low reset signal for ucie apb domain";
            hw = r;
            sw = rw;
            reset = 0; // Tile is held in reset by default
        } n;
    } rst_apb;

    reg phy_mode {
        desc = "PHY streaming bandwidth mode for this tile";
        field {
            desc = "0 = full bandwidth (native PHY width), 1 = half bandwidth
                     (PHY width halved, duplicated across both halves of the bus)";
            hw = r;
            sw = rw;
            reset = 0; // Full bandwidth by default
        } half_bw_en;
    } phy_mode;
};

`endif // __GW_UCIE_TILE_REGS_RDL__
