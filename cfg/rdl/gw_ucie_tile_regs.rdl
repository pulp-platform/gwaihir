// Copyright 2025 ETH Zurich and University of Bologna.
// Solderpad Hardware License, Version 0.51, see LICENSE for details.
// SPDX-License-Identifier: SHL-0.51

`ifndef __GW_UCIE_TILE_REGS_RDL__
`define __GW_UCIE_TILE_REGS_RDL__

addrmap gw_ucie_tile_regs {
    reg clock {
        field {
            desc = "Clock gate control for tile";
            hw = r;
            sw = rw;
            reset = 0; // Clock is disabled by default
        } en;
    } clk;

    reg rst_axi {
        desc = "Reset control for tile";
        field {
            desc = "active low reset signal for ucie axi domain";
            hw = r;
            sw = rw;
            reset = 0; // Tile is held in reset by default
        } n;
    } rst_axi;

    reg rst_apb {
        desc = "Reset control for tile";
        field {
            desc = "active low reset signal for ucie apb domain";
            hw = r;
            sw = rw;
            reset = 0; // Tile is held in reset by default
        } n;
    } rst_apb;

    reg phy_mode {
        desc = "PHY streaming bandwidth mode for this tile";
        field {
            desc = "0 = full bandwidth (native PHY width), 1 = half bandwidth
                     (PHY width halved, duplicated across both halves of the bus)";
            hw = r;
            sw = rw;
            reset = 0; // Full bandwidth by default
        } half_bw_en;
    } phy_mode;

    reg link_ctrl {
        desc = "UCIe RDI link control";
        field {
            desc = "Request the RDI ACTIVE state (lp_state_req) and keep the PHY
                     clocks awake (lp_wake_req)";
            hw = r;
            sw = rw;
            reset = 0; // Link is not requested by default
        } en;
    } link_ctrl;

    reg link_status {
        desc = "UCIe RDI link status";
        field {
            desc = "pl_state_sts == ACTIVE";
            hw = w;
            sw = r;
        } active[0:0];
        field {
            desc = "Fatal, non-fatal or training error reported by the PHY";
            hw = w;
            sw = r;
        } error[1:1];
        field {
            desc = "Sticky: at least one received RDI word was dropped";
            hw = w;
            sw = r;
        } rx_drop_err[2:2];
        field {
            desc = "Raw RDI link state (pl_state_sts)";
            hw = w;
            sw = r;
        } state[7:4];
        field {
            desc = "Saturating count of dropped RDI words";
            hw = w;
            sw = r;
        } rx_drop_count[31:16];
    } link_status;
};

`endif // __GW_UCIE_TILE_REGS_RDL__
